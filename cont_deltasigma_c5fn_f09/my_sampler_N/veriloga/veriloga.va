`include "discipline.h"
`include "constants.h"

// $Date: 1997/08/28 05:53:35 $
// $Revision: 1.1 $
//
//
// Based on the OVI Verilog-A Language Reference Manual, version 1.0 1996
//
//

//--------------------
// my sampler
//
// -  sampler
//
// sigin:	(val,flow)
//
// INSTANCE parameters
//    tsample  = how often input is sampled	[s]
//    log_time = if time should be logged to in file; 1=>yes, 0=>no []
//
// MODEL parameters
//    {none}
//
// Samples an 'sigin' every 'tsample' and writes the results to the file
// 'filename' and labels the data with "Sine Wave". The time variable will be
// recorded if 'log_time' is '1'.
//

module my_sampler_N (sigin1, sigin2);
input sigin1, sigin2;
electrical sigin1, sigin2;
parameter real tsample=1u;
parameter integer log_time=0;
integer sigout_file;
real next_sample_time;

   analog begin

      @ ( initial_step ) begin
	 sigout_file = $fopen( "%C:r.dat" );
	 $fstrobe(sigout_file,"# %s sampled at %g Hz.", "Sine Wave", 1/tsample);
	 $fstrobe(sigout_file,"# Generated by Spectre from instance `%M'");
	 next_sample_time = tsample;
      end

      @ ( timer( next_sample_time )) begin
	 if (log_time == 1 ) begin
            $fstrobe(sigout_file, "%-.10g\t%-.10g\t%-.10g", $abstime, V(sigin1),V(sigin2));
	 end else begin
            $fstrobe(sigout_file, "%-.10g\t%-.10g", V(sigin1), V(sigin2));
         end
      end
      if ($abstime >= next_sample_time)
         next_sample_time = next_sample_time + tsample;

   @ ( final_step ) begin
      $fclose(sigout_file);
   end
   end
endmodule
