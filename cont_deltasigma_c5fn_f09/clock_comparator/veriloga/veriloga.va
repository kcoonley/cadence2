//VerilogA for cont_deltasigma_c5fn_f09, clock_comparator, veriloga

`include "constants.vams"
`include "disciplines.vams"

// $Date: 1997/08/28 05:48:45 $
// $Revision: 1.1 $
//
//
// Based on the OVI Verilog-A Language Reference Manual, version 1.0 1996
//
//

//--------------------
// comparator
//
// -  comparator
//
// sigin:	(val,flow)
// sigref:	reference to which 'sigin' is compared (val,flow)
// sigout:	comparator output (val,flow)
//
// INSTANCE parameters
//    sigout_high  = maximum output of the comparator  (val)
//    sigout_low   = minimum output of the comparator  (val)
//    sigin_offset = subtracted from 'sigin' before comparason to sigref (val)
//    comp_slope   = determines the sensitivity of the comparator []
//
// MODEL parameters
//    {none}
//
// Compares ('sigin'-'sigin_offset') to 'sigref' - the output is related to
// their difference by a tanh relationship.
//
// If the difference >>> 'sigref', 'sigout' is 'sigout_high'.
// If the difference = 'sigref', 'sigout' is ('sigout_high' + 'sigout_low')/2.
// If the difference <<< 'sigref', 'sigout' is 'sigout_low'.
// Intermediate points are fitting to a tanh scaled by 'comp_slope'.
//

module clock_comparator(sigin, sigref, vclk, sigout);
input sigin, sigref, vclk;
output sigout;
electrical sigin, sigref, vclk, sigout;
parameter real sigout_high = 10;
parameter real sigout_low = -10;
parameter real sigin_offset = 0;
parameter real comp_slope = 1000;
parameter real vtrans_clk = 2.5;
real vout_val;

   analog begin

      @ ( initial_step ) begin
	 V(sigout) <+ 0;
      end

      @ (cross(V(vclk) - vtrans_clk, 1))
      	vout_val = 0.5 * (sigout_high - sigout_low) * tanh(comp_slope*(V(sigin, sigref)- sigin_offset)) + (sigout_high + sigout_low)/2;

     V(sigout) <+ vout_val;

   end
endmodule
