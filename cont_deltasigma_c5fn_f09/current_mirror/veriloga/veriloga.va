`include "discipline.h"
`include "constants.h"

// $Date: 1997/08/28 05:45:21 $
// $Revision: 1.1 $
//
//
// Based on the OVI Verilog-A Language Reference Manual, version 1.0 1996
//
//

`define PI  	3.14159265358979323846264338327950288419716939937511

//--------------------
// Current source model
//
// - current source
//
// iin:		input current [V,A]
// iout:	output current [V,A]
// vout:	output voltagee [V,A]
// vsply_p:	positive supply voltage [V,A]
// vsply_n:	negative supply voltage [V,A]
//
// INSTANCE parameters
//    ileak	     = leakage current [A]
//    rout           = output resistance [Ohms]
//    vsoft          = soft output limiting value [V]
//
// MODEL parameters
//    {none}
//

module currentfeedback(iin, vctrlp, vctrln, vsply_n, iout);
input iin, vctrlp, vctrln;
output iout;
inout vsply_n;
electrical iin, vctrlp, vctrln, vsply_n;
electrical iout;
parameter real vdd = 5;
parameter real ileak = 0.1e-12;
parameter real rout = 1e9;
parameter real vsoft = 0.1;
parameter real vth = 0.5;
parameter real vclamp_upper = 5;
parameter real vclamp_lower = 0;

  real sigin_val, output_expr, vdt_val, sigout_val, vout_val;
  integer sw_state, o_state, result;

   analog begin

      @ ( initial_step or initial_step("dc") ) begin
      end

      sigin_val = I(iin, vsply_n);
      vout_val = V(iout, vsply_n);

      sw_state = (V(vctrlp, vctrln) > vth) ? 1: 0;

      @ (cross(V(vctrlp, vctrln) - vth, 1, 1.0, vctrlp.potential.abstol) )	           sw_state = 1;
      @ (cross(V(vctrlp, vctrln) - vth, -1, 1.0, vctrlp.potential.abstol) )
           sw_state = 0;

      if (sw_state == 0)
         sigout_val =  ileak;
      else
         sigout_val = sigin_val;

     if (vout_val < vclamp_lower)
        sigout_val = 0;
     else
        sigout_val = sigout_val;

     I(iout, vsply_n) <+ sigout_val;

   end
endmodule
